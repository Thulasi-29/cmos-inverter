** sch_path: /home/vlsi/inverter/xschem/inverter_tb.sch
.subckt inverter_tb out in
*.PININFO out:O in:O
x1 net1 in out 0 inverter
V1 in 0 PWL(0 0 20n 0 900n 1.8)
V2 net1 0 1.8
**** begin user architecture code

.lib /usr/local/share/pdk/sky130A/libs.tech/ngspice/sky130.lib.spice tt

.control
tran 1n 1u
plot V(in) V(out)
.endc

**** end user architecture code
.ends

* expanding   symbol:  inverter.sym # of pins=4
** sym_path: /home/vlsi/inverter/xschem/inverter.sym
** sch_path: /home/vlsi/inverter/xschem/inverter.sch
.subckt inverter vdd in out vss
*.PININFO in:I out:O vss:B vdd:B
XM1 out in vss vss sky130_fd_pr__nfet_01v8 L=0.18 W=1 nf=4.5
XM2 out in vdd vdd sky130_fd_pr__pfet_01v8 L=0.18 W=3 nf=3
.ends
